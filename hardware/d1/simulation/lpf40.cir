SkyWave lpf40 nominal LPF; ideal LC, 50 ohm terminations
V1 source 0 AC 1
RS source n0 50
RL n3 0 50
C1 n0 0 150p
L1 n0 n1 1200n
C2 n1 0 620p
L2 n1 n2 1800n
C3 n2 0 620p
L3 n2 n3 1200n
C4 n3 0 150p
.control
set wr_singlescale
set wr_vecnames
ac dec 150 2333333.3333333335 29200000.0
let s21_db = db(v(n3)*2)
wrdata lpf40.dat s21_db
quit
.endc
.end
